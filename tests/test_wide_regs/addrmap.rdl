addrmap test {
  default accesswidth = 8;
  default regwidth = 16;
  default sw = rw;
  default hw = rw;

  reg r1 {
    field {} f1[8];
    field {} f2[8];
  };

  reg r2 {
    field {} f1[2];
    field {} f2[15:13];
  };

  reg r3 {
    regwidth = 8;
    field {} f1[1];
    field {} f2[6:4];
  };

  reg r5 {
    regwidth = 16;
    field {} f0[0:0];
    field {} f1[1:1];
    field {} f2[2:2];
    field {} f3[3:3];
    field {} f4[4:4];
    field {} f5[5:5];
    field {} f6[6:6];
    field {} f7[7:7];
    field {} f8[8:15];
  };

  r1 r1_single   @ 0;
  r1 r1_array[4] @ 2;
  r2 r2_single   @ 18;
  r3 r3_notwide  @ 20;
  r5 r5          @ 22;
};
