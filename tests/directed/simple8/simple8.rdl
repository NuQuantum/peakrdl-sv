addrmap simple8 {
    name = "simple8";
    desc = "An 8-bit regfile";
    default accesswidth = 8;
    default regwidth = 8;
    default sw=rw;
    default hw=rw;

    regfile my_regfile {
        reg {
            name = "Control";
            desc = "Register description";
            field {
                name = "Field name";
                desc = "Field description";
                hw   = r;
                sw   = rw;
            } en[1] = 0x0;
            field {
                name = "Field name";
                desc = "Field description";
                hw   = r;
                sw   = rw;
            } sel[2] = 0x0;
        } control ;
        reg {
            name = "Status";
            desc = "Register description";
            field {
                name = "Interrupt request";
                desc = "Field description";
                hw   = w;
                sw   = r;
            } irq[1] = 0x0;
        } status ;
        reg {
            name = "Read Write";
            desc = "Register description";
            field {
                name = "Field name";
                desc = "Field description";
                hw   = rw;
                sw   = rw;
            } divlen[6]; // no default value
        } clkdiv ;
    } ;

    reg ptime {
        name = "IRQ";
        desc = "Playtime";
        field {
            name = "Sometime";
            desc = "over the rainbow";
            hw = rw;
            sw = rw;
        } playtime[7:0] = 0x1;
    } ;

    reg stb {
        name = "stb";
        field {
            name = "write to stb";
            hw = r;
            sw = w;
            swmod;
        } data[7:0] = 0x1;
    } ;

    reg wide_reg {
        regwidth = 16;
        field {} data0[7:0] = 0;
        field {} data1[15:8] = 0;
    };

    reg data {
        field {} a[8];
    };

    reg const {
        field {hw = r; sw = r;} data[8] = 0xAB;
    };

    internal my_regfile  my_regfile[2]   @ 0x0;
    internal ptime       my_ptime        @ 0xC;
    internal stb         my_stb          @ 0xD;
    internal wide_reg    my_wide         @ 0x10;
    internal wide_reg    my_array[4]     @ 0x20;
    internal data        my_data[2]      @ 0x30;
    external data        my_data_ext     @ 0x40;
    internal wide_reg    my_wide_2       @ 0x50;
    // internal const       const           @ 0x60; REVISIT: const is broken
    internal ptime       my_ptime_high   @ 0xFF8;
    internal ptime       my_ptime_high1  @ 0xFFC;
};
